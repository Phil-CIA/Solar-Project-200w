* LTspice startup-current experiment for the Rev 0 LM51772-style power stage.
* Behavioral envelope model; not an LM51772 vendor macromodel.

R_GNDREF PWR_NEG 0 1u

.param VIN=6
.param FSW=610k
.param TSS=100u
.param VOUT_TARGET=12.83
.param DUTY_START=0.05
.param DUTY_END={1-VIN/VOUT_TARGET}
.param LVAL=1u
.param L_DCR=5m
.param RSOURCE=30
.param COUT=220u
.param COUT_ESR=25m
.param RLOAD=1k
.param GATE_HIGH=10
.param DEAD=40n

V_PV PV_SOURCE PWR_NEG {VIN}
R_SOURCE PV_SOURCE PV_IN_POS {RSOURCE}
CIN PV_IN_POS PWR_NEG 50u

* Boost-mode diagonal pairs:
* charge: HO1 + LO2; transfer: LO1 + HO2.
B_HO1 HO1 PWR_NEG V={if(mod(time,1/FSW)<(1/FSW)*(DUTY_START+(DUTY_END-DUTY_START)*min(time/TSS,1)),GATE_HIGH,0)}
B_LO2 LO2 PWR_NEG V={if(mod(time,1/FSW)<(1/FSW)*(DUTY_START+(DUTY_END-DUTY_START)*min(time/TSS,1)),GATE_HIGH,0)}
B_LO1 LO1 PWR_NEG V={if(mod(time,1/FSW)>=(1/FSW)*(DUTY_START+(DUTY_END-DUTY_START)*min(time/TSS,1)+DEAD*FSW),GATE_HIGH,0)}
B_HO2 HO2 PWR_NEG V={if(mod(time,1/FSW)>=(1/FSW)*(DUTY_START+(DUTY_END-DUTY_START)*min(time/TSS,1)+DEAD*FSW),GATE_HIGH,0)}
R_LO2_BIAS LO2 PWR_NEG 1G

.model SWNMOS SW(RON=20m ROFF=100MEG VT=4 VH=0.3)
.model DBODY D(IS=1e-12 RS=5m CJO=250p TT=40n)

S_HS1 PV_IN_POS SW_1 HO1 PWR_NEG SWNMOS
D_HS1 SW_1 PV_IN_POS DBODY
S_LS1 SW_1 PWR_NEG LO1 PWR_NEG SWNMOS
D_LS1 PWR_NEG SW_1 DBODY

R22 SW_1 CSB_2 1m
L2 CSB_2 L2_INT {LVAL}
R_L2 L2_INT SW_2 {L_DCR}

S_HS2 V_OUT SW_2 HO2 PWR_NEG SWNMOS
D_HS2 SW_2 V_OUT DBODY
S_LS2 SW_2 PWR_NEG LO2 PWR_NEG SWNMOS
D_LS2 PWR_NEG SW_2 DBODY

R_COUT V_OUT VOUT_CAP {COUT_ESR}
C_OUT VOUT_CAP PWR_NEG {COUT}
R_LOAD V_OUT PWR_NEG {RLOAD}
R_OUTLINK V_OUT CHG_OUT_POS 5m
C_CHG CHG_OUT_POS PWR_NEG 22u

R_LEAK_SW1 SW_1 PWR_NEG 50Meg
R_LEAK_SW2 SW_2 PWR_NEG 50Meg
R_LEAK_VOUT V_OUT PWR_NEG 50Meg
C_SW1 SW_1 PWR_NEG 100p
C_SW2 SW_2 PWR_NEG 100p

.options plotwinsize=0
.tran 20n 20m 0 20n
.save V(PV_IN_POS) I(V_PV) I(L2) V(L2_INT) V(V_OUT) V(CHG_OUT_POS) V(SW_1) V(SW_2) V(HO1) V(LO1)
.meas TRAN VOUT_FINAL FIND V(CHG_OUT_POS) AT=20m
.meas TRAN IIN_PEAK MAX ABS(I(V_PV)) FROM=0 TO=20m
.meas TRAN IL_PEAK MAX ABS(I(L2)) FROM=0 TO=20m
.meas TRAN IIN_AVG AVG ABS(I(V_PV)) FROM=15m TO=20m
.meas TRAN IL_AVG AVG ABS(I(L2)) FROM=15m TO=20m
.meas TRAN SW1_PEAK MAX ABS(V(SW_1)) FROM=0 TO=20m
.meas TRAN SW2_PEAK MAX ABS(V(SW_2)) FROM=0 TO=20m
.meas TRAN HO1_PEAK MAX V(HO1) FROM=0 TO=20m
.meas TRAN LO1_PEAK MAX V(LO1) FROM=0 TO=20m

.end
