V1 n1 0 1
R1 n1 0 1k
.op
.print V(n1)
.end
