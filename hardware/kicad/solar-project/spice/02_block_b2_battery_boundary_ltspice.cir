* B2 - Output boundary and battery interface
* LTspice export from 02_block_b2_battery_boundary.cir

.param B2_VCHG=14.2
.param B2_USE_INTERNAL_CHG=1
.param B2_R_FEED_ON=1m
.param B2_R_FEED_OFF=1G
.param B2_RFUSE=20m

.param B2_VBAT_OCV=12.8
.param B2_RBAT_ESR=35m
.param B2_RBAT_POL=0.35
.param B2_CBAT_POL=2

.param B2_RPACK_LEAK=3k

* Optional local charger source for stand-alone runs.
V_CHG_INT CHG_SRC PWR_NEG DC {B2_VCHG}
R_CHG_FEED CHG_SRC CHG_OUT_POS {B2_R_FEED_ON + (B2_R_FEED_OFF-B2_R_FEED_ON)*(1-B2_USE_INTERNAL_CHG)}

* F2 first-pass series model.
R_F2 CHG_OUT_POS BAT_BUS_POS {B2_RFUSE}

* Battery equivalent:
* OCV source + ESR + one polarization branch.
R_GNDREF_B2 PWR_NEG 0 1u
V_BAT_OCV BAT_OCV PWR_NEG DC {B2_VBAT_OCV}
R_BAT_ESR BAT_BUS_POS BAT_POL {B2_RBAT_ESR}
R_BAT_POL BAT_POL BAT_OCV {B2_RBAT_POL}
C_BAT_POL BAT_POL BAT_OCV {B2_CBAT_POL}

* Small pack leakage/load placeholder at boundary.
R_PACK_LEAK BAT_BUS_POS PWR_NEG {B2_RPACK_LEAK}

.op
.tran 100u 200m
.meas tran Vbat_final FIND V(BAT_BUS_POS) AT=200m
.meas tran Ichg_final FIND I(V_CHG_INT) AT=200m

.end
