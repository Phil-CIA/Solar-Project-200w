* Solar Project Rev0 startup inrush model for LTspice
* Behavioral system-level model; not an LM51772 silicon macromodel.

.param VPV_SET=6.49
.param IPV_MAX=20m
.param CIN=530u
.param COUT=1400u
.param LVAL=1u
.param L_DCR=420m
.param VOUT_SET=6.49
.param TSS=1s
.param EFF=0.80
.param RPV_LEAK=10Meg
.param RLOAD=1Meg

* Current-limited PV boundary.
B_PV 0 PV I={IPV_MAX}
R_PV_LEAK PV 0 {RPV_LEAK}
CIN_EQ PV 0 {CIN} IC=0

* Manufactured-build inductor values retained for reference.
L_MAIN SW VOUT_INT {LVAL} IC=0
R_LMAIN VOUT_INT VOUT {L_DCR}

* Output capacitor bank.
COUT_EQ VOUT 0 {COUT} IC=0
R_LOAD VOUT 0 {RLOAD}

* Linear soft-start target.
B_SS SS 0 V={min(VOUT_SET,VOUT_SET*time/TSS)}

* Available output power after conversion loss.
B_PAV 0 P_AV I={EFF*max(V(PV),0)*IPV_MAX}

* Charge current is limited by soft-start and available power.
B_CHARGE 0 VOUT I={u(V(SS)-V(VOUT))*min(COUT*VOUT_SET/TSS,V(P_AV)/max(V(VOUT),0.1))}

* Zero-volt probe permits direct input-current measurement.
V_IIN PV PV_CONV 0
B_CONVERTER PV_CONV 0 I={u(V(SS)-V(VOUT))*max(0,V(VOUT)*min(COUT*VOUT_SET/TSS,V(P_AV)/max(V(VOUT),0.1))/max(EFF*max(V(PV),0.1),0.1))}

* Numerical reference resistors for unused behavioral nodes.
R_STATE1 P_AV 0 1G
R_STATE2 SS 0 1G
R_LEAK_SW SW 0 50Meg

.options plotwinsize=0 reltol=1e-4
.tran 1m 2s startup
.save V(PV) V(VOUT) V(SS) I(V_IIN)
.meas tran VOUT_1S FIND V(VOUT) AT=1s
.meas tran VOUT_END FIND V(VOUT) AT=2s
.meas tran VPV_MIN MIN V(PV) FROM=0 TO=2s
.meas tran IIN_MAX MAX I(V_IIN) FROM=0 TO=2s
.end
