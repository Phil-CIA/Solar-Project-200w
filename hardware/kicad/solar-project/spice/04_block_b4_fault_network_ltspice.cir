* B4 - Fault threshold and comparator network (OVP/OCP)
* LTspice export from 04_block_b4_fault_network.cir

.param USE_INTERNAL_3V3=1
.param USE_INTERNAL_STIM=1
.param V3V3=3.3
.param VBAT_IN=14.4
.param VOCP_IN=0.15
.param R_FEED_ON=1m
.param R_FEED_OFF=1G

* Optional local supplies/stimuli for stand-alone runs.
V_GNDREF PWR_NEG 0 0
V_3V3_INT V3V3_INT PWR_NEG DC {V3V3}
R_3V3_FEED V3V3_INT CTRL_3V3 {R_FEED_ON + (R_FEED_OFF-R_FEED_ON)*(1-USE_INTERNAL_3V3)}

V_BAT_STIM BAT_STIM PWR_NEG DC {VBAT_IN}
R_BAT_FEED BAT_STIM BAT_BUS_POS {R_FEED_ON + (R_FEED_OFF-R_FEED_ON)*(1-USE_INTERNAL_STIM)}

V_OCP_STIM OCP_STIM PWR_NEG DC {VOCP_IN}
R_OCP_FEED OCP_STIM OCP_MEAS {R_FEED_ON + (R_FEED_OFF-R_FEED_ON)*(1-USE_INTERNAL_STIM)}

* OVP and OCP sense networks
R20 BAT_BUS_POS OVP_SENSE 499k
R47 OVP_SENSE PWR_NEG 10k

R49 OCP_MEAS OCP_SENSE 1m
R50 OCP_SENSE PWR_NEG 10k

* Reference networks from CTRL_3V3
R21 CTRL_3V3 OVP_REF 102k
R48 OVP_REF PWR_NEG 10k

R51 CTRL_3V3 OCP_REF 2.7k
R52 OCP_REF PWR_NEG 1k

* LMV393-like open-collector behavior (idealized):
* Comparator pulls output low when (+) exceeds (-).
.model SWOC SW(RON=5 ROFF=1e12 VT=0 VH=1m)
S_OVP FAULT_OVP PWR_NEG OVP_SENSE OVP_REF SWOC
S_OCP FAULT_OCP PWR_NEG OCP_SENSE OCP_REF SWOC

* Output pullups present in hardware
R19 CTRL_3V3 FAULT_OVP 10k
R53 CTRL_3V3 FAULT_OCP 10k

.op
.print op V(OVP_SENSE) V(OVP_REF) V(FAULT_OVP)
.print op V(OCP_SENSE) V(OCP_REF) V(FAULT_OCP)

.dc V_BAT_STIM 8 30 0.5
.print dc V(OVP_SENSE) V(FAULT_OVP)
.meas dc BAT_TRIP WHEN V(OVP_SENSE)=V(OVP_REF)

.end
