* B3 - Control rail supply path to CTRL_3V3
* LTspice export from 03_block_b3_control_rail.cir

.param VCTRLIN=18

* Ensure global reference node is tied to LTspice node 0
R_GNDREF_B3 PWR_NEG 0 1u

V_CTRLIN CTRL_SUPPLY_IN PWR_NEG DC {VCTRLIN}

* Placeholder ideal regulator model
E_REG CTRL_3V3 PWR_NEG VALUE={ if(v(CTRL_SUPPLY_IN,PWR_NEG)>4.0, 3.3, 0) }
R_REG_OUT CTRL_3V3 PWR_NEG 1k

* Optional USB bench fallback source placeholder
V_USB USB_5V_IN PWR_NEG DC 5
R_USB_ISO USB_5V_IN CTRL_SUPPLY_IN 10MEG

.dc V_CTRLIN 0 60 0.5
.print dc V(CTRL_3V3) V(CTRL_SUPPLY_IN)

.end
